.title Overcurrent Protection 48V Bus

* -----------------------------------------------------------------------
* 48V bus overcurrent protection simulation
*
* Normal: 10A load -> V_sense = 50mV < 75mV -> gate HIGH -> switch ON
* Fault:  25A load -> V_sense = 125mV > 75mV -> gate pulled LOW -> OFF
* Expected trip time: ~531ns (comparator 150ns + gate RC 381ns)
* -----------------------------------------------------------------------

* 48V bus supply
Vbus    VBUS  GND  48

* Series protection switch modelling IRF2907
* S element: n+  n-  ctrl+  ctrl-  model
S1      VBUS  BUS_OUT  GATE  GND  SWMOD
.model  SWMOD  SW(Ron=0.0045 Roff=1MEG Vt=4.0 Vh=0.5)

* Gate pull-up resistor holds gate at 12V (switch ON) during normal operation
Vgvcc   GVCC  GND  12
Rpullup GVCC  GATE  10k

* Gate capacitance (IRF2907 Ciss ~3.5nF, determines gate fall time)
Cgate   GATE  GND  3.5n  IC=12

* Sense resistor: 5 mOhm
* V_sense = V(BUS_OUT) - V(SENSE_LO) = Iload x 5mOhm
Rsense  BUS_OUT  SENSE_LO  5m

* Bus capacitor (holds bus voltage briefly during trip)
Cbus    SENSE_LO  GND  100u  IC=48

* Load: 10A normal, 25A fault at t=50us
Iload   SENSE_LO  GND  PWL(0 10  50u 10  50.1u 25  500u 25)

* Trip threshold: 75mV = 15A x 5mOhm
Vref    VREF  GND  75m

* Behavioural LM393 comparator using u() unit-step function
* u(x) = 1 when x > 0, 0 when x < 0
* V_sense = V(BUS_OUT)-V(SENSE_LO)
* Normal (V_sense < Vref): u(Vref - V_sense) = 1 -> output = 12V (gate HIGH)
* Fault  (V_sense > Vref): u(Vref - V_sense) = 0 -> output = 0V  (gate LOW)
Bcomp   CNODE  GND  V=12*u(V(VREF)-(V(BUS_OUT)-V(SENSE_LO)))
Rcomp   CNODE  GATE  100

* Transient: 10ns step, run to 500us, use initial conditions
.tran 10n 500u UIC

* Batch run (ngspice -b overcurrent_protection.cir)
.control
run
wrdata spice_output.dat v(BUS_OUT) v(SENSE_LO) v(GATE) I(Iload)
quit
.endc

* LTspice probe (comment out .control block above when using LTspice)
.probe v(BUS_OUT) v(SENSE_LO) v(GATE) I(Iload)

.end
